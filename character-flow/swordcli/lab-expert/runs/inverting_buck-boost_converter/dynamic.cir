Dynamic Circuit: Inverting buck-boost converter

* Circuit
V1 1 0 DC 12
Rin 1 2 10k
L1 2 0 100u
D1 3 2 D1N4148
C1 3 0 470u
Rload 3 0 10
.model D1N4148 D(Is=2.52n Rs=0.568 N=1.752 Cjo=4p M=0.333 tt=5.76n)

* Analysis

.tran 10u 10m

.control
    run
    setplot tran1
    wrdata runs/inverting_buck-boost_converter/iv_data_2_tran.txt V(2) -I(V1)
.endc
.end
